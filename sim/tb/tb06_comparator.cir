* TB06 - Comparator stage (U9 TLV7034 unit A) + LED indicator
*
* PART CHANGE, 2026-07-16: the schematic's comparator was changed from
* LM339N (U10) to PTLV7034PWR (U9, TI TLV7034, quad, TSSOP-14). This deck was
* rewritten to match. The LM339 revision of this deck -- which is what
* RESULTS.md's "CRITICAL" section is built on -- is preserved in git history
* at commit f0c9fff. Do not read the two sets of numbers as one series.
*
* Schematic (verified against the .kicad_sch netlist, not assumed):
*   U9 pin 3  (+IN A) = N1_SUM        (pin 5 / 10 for N2 / N3)
*   U9 pin 2  (-IN A) = V_REF_BUF = 1.65 V (shared by all three channels)
*   U9 pin 1  (OUT A) = push-pull
*   U9 pin 4  = +3.3V (C15 decoupling), pin 11 = GND
*   +3.3V -- R34 -- D4 (LED) -- OUT A    => LED lights when OUT LOW
*   Channel D is parked (+IN D = +3.3V, -IN D = GND) with OUT D no-connected.
*
* NOTE the polarity: +IN is N1_SUM, so OUT is LOW when N1_SUM < 1.65, i.e.
* when the weighted sum is positive -> LED ON when the neuron fires. Same
* semantics as the LM339 revision; the pinout changed, the logic did not.
*
* WHAT CHANGED IN THE QUESTIONS BEING ASKED:
*   The LM339 revision had to relocate the reference to 1.0 V in test (C),
*   because 1.65 V was outside that part's common-mode range and the
*   hysteresis question could not otherwise be isolated from the common-mode
*   question. The TLV7034's inputs are rail-to-rail, so (C) now runs at the
*   REAL 1.65 V reference. That is the point of the part change.
*
*   (A) As-designed DC sweep: does it compare correctly with IN- = 1.65?
*   (B) CM map: is there a ceiling anywhere in the operating range?
*   (C) Hysteresis/chatter at the real 1.65 V reference.
*   (D) LED drive current -- SEE THE WARNING ON TEST (D) BEFORE QUOTING IT.
*
* CM RANGE FACTS:
*   - TLV7034 datasheet (SLVSE13J): VCM = V- to V+ + 0.1 => 0 .. 3.40 V at 3.3 V
*   - TI's macromodel flags out-of-range only above an ABSOLUTE 6 V or below
*     V- - 0.3 V. Validated in TB10. Neither is reachable here (N1_SUM tops
*     out at 3.10 V), so the model's mid-supply invalidity flag never trips.
*   Contrast the LM339: datasheet 1.80 V ceiling, model 1.30 V, reference at
*   1.65 V -- above both, which is why that part could not work at all.
*
* From TB05: N1_SUM operating range is 0.20 V .. 3.10 V.

.include ../models/TLV7034.lib
.options gmin=100f
.param VDD=3.3
* R_LED: 1k is what the schematic currently draws. See TB06(D).
.param RLED=1k
* .param alone is not visible inside .control; .csparam exports it there.
.csparam rled={RLED}

* Red LED, tuned to Vf ~ 1.9 V at 1 mA (WL-TMRC 5mm, Wurth 151051RS11000;
* datasheet Vf 2.1 V typ / 2.5 V max at 20 mA). Exact Vf shifts the LED
* current, not the comparator logic.
.model LED_RED D(IS=2e-18 N=2.0 RS=2 CJO=30p)

Vdd  vdd 0 DC {VDD}

* --- (A) as-designed: IN- pinned at the 1.65 V pseudo-ground ---
Vrefa nrefa 0 DC 1.65
Vsum  nsum  0 DC 1.65
XC1   nsum nrefa vdd 0 outa TLV7034
R34   vdd  nled  {RLED}
D4    nled outa  LED_RED

* --- (B) CM map: IN- parked at 0.80 V and IN+ swept to the rail. Kept
* --- identical in form to the LM339 revision so the two are comparable.
Vrefb nrefb 0 DC 0.80
Vsumb nsumb 0 DC 0.5
XC2   nsumb nrefb vdd 0 outb TLV7034

* --- (C) chatter rig, now at the REAL 1.65 V reference ---
Vrefc nrefc 0 DC 1.65
* Slow crossing: the LDR has 60 ms rise, so N_SUM slews on the order of V/s.
* Ramp 1.64 -> 1.66 over 40 ms == 0.5 V/s at the sum node. Identical slew to
* the LM339 revision's 0.99 -> 1.01 ramp, just centred on the real reference.
Vrampc nrampc 0 DC 0 PWL(0 1.64 40m 1.66)
* Interference: mains-lit rooms flicker at 100/120 Hz and an LDR sees it
* directly. 2 mV pk at the sum node, phase 180 so the flicker's steepest
* FALLING edge lands on the crossing -- the worst case, per the LM339 run.
*   interference peak slope = A*2*pi*f = 2mV * 628 = 1.26 V/s
*   signal slope at the sum  = 0.5 V/s
* On the LM339 (zero hysteresis) 1.26 > 0.5 meant ANY flicker above ~0.8 mV
* chattered. The TLV7034's internal hysteresis is what this test now probes:
* 4 mV pk-pk of flicker against a 7 mV (model) window should not re-cross.
Vflick nflick nrampc SIN(0 2m 100 0 0 180)
* Broadband noise on top, 200 uV RMS, 1 us step.
Vnoise nnz nflick DC 0 trnoise(200u 1u 0 0)
XC3    nnz nrefc vdd 0 outc TLV7034

.control
set wr_singlescale

echo "==================================================================="
echo "TB06 (A) AS DESIGNED: IN- = V_REF_BUF = 1.65 V, sweep N1_SUM"
echo "==================================================================="
dc Vsum 0 3.305 0.005
meas dc a_0v2  find v(outa) at=0.2
meas dc a_1v0  find v(outa) at=1.0
meas dc a_1v4  find v(outa) at=1.4
meas dc a_1v6  find v(outa) at=1.6
meas dc a_1v7  find v(outa) at=1.7
meas dc a_2v0  find v(outa) at=2.0
meas dc a_3v1  find v(outa) at=3.1
echo "  N1_SUM=0.20 (below ref -> expect LED ON,  OUT LOW)  -> OUT = $&a_0v2 V"
echo "  N1_SUM=1.00 (below ref -> expect LED ON,  OUT LOW)  -> OUT = $&a_1v0 V"
echo "  N1_SUM=1.40 (below ref -> expect LED ON,  OUT LOW)  -> OUT = $&a_1v4 V"
echo "  N1_SUM=1.60 (below ref -> expect LED ON,  OUT LOW)  -> OUT = $&a_1v6 V"
echo "  N1_SUM=1.70 (above ref -> expect LED OFF, OUT HIGH) -> OUT = $&a_1v7 V"
echo "  N1_SUM=2.00 (above ref -> expect LED OFF, OUT HIGH) -> OUT = $&a_2v0 V"
echo "  N1_SUM=3.10 (above ref -> expect LED OFF, OUT HIGH) -> OUT = $&a_3v1 V"
meas dc trip when v(outa)=1.65 rise=1
echo "  >>> Trip point = $&trip V   [target 1.65]"
meas dc omin MIN v(outa)
meas dc omax MAX v(outa)
echo "  >>> Output range: $&omin .. $&omax V  (neither end stuck at 1.65)"

echo ""
echo "  --- (D) LED CURRENT ---"
echo "  WARNING: the model's output stage is two idealised BJTs (NPN1/PNP1,"
echo "  LEVEL=1, RC=1). TB10(C) measured its VOL at 3 mA as 77 mV against a"
echo "  datasheet 250 mV typ / 350 mV max. The model is OPTIMISTIC about VOL,"
echo "  so the LED current below is an UPPER BOUND, not a prediction. Size"
echo "  R34-R36 from the datasheet, not from this number."
let ledi = (v(vdd)-v(nled))/$&rled
meas dc li_0v2 find ledi at=0.2
meas dc li_3v1 find ledi at=3.1
echo "  R34 = $&rled ohm"
echo "  LED current at N1_SUM=0.20 (LED ON)  = $&li_0v2 A   [model, optimistic]"
echo "  LED current at N1_SUM=3.10 (LED OFF) = $&li_3v1 A"
wrdata results/tb06a_asdesigned.txt v(outa) ledi

echo ""
echo "==================================================================="
echo "TB06 (B) COMMON-MODE MAP: IN- = 0.80 V (valid), sweep IN+ upward"
echo "==================================================================="
echo "  Correct behaviour: OUT LOW while IN+ < 0.80, OUT HIGH above it, and"
echo "  HIGH persisting all the way to the rail. On the LM339 this is where"
echo "  the part left a valid HIGH at 1.30045 V."
dc Vsumb 0 3.305 0.0025
meas dc b_0v5 find v(outb) at=0.5
meas dc b_0v9 find v(outb) at=0.9
meas dc b_1v2 find v(outb) at=1.2
meas dc b_1v3 find v(outb) at=1.3
meas dc b_1v4 find v(outb) at=1.4
meas dc b_1v8 find v(outb) at=1.8
meas dc b_2v5 find v(outb) at=2.5
meas dc b_3v1 find v(outb) at=3.1
echo "  IN+=0.50 (below ref -> expect LOW)  -> OUT = $&b_0v5 V"
echo "  IN+=0.90 (above ref -> expect HIGH) -> OUT = $&b_0v9 V"
echo "  IN+=1.20 (above ref -> expect HIGH) -> OUT = $&b_1v2 V"
echo "  IN+=1.30 (LM339 model ceiling)      -> OUT = $&b_1v3 V"
echo "  IN+=1.40 (past LM339 model ceiling) -> OUT = $&b_1v4 V"
echo "  IN+=1.80 (LM339 datasheet ceiling)  -> OUT = $&b_1v8 V"
echo "  IN+=2.50 (N1_SUM reaches here)      -> OUT = $&b_2v5 V"
echo "  IN+=3.10 (N1_SUM max)               -> OUT = $&b_3v1 V"
meas dc bmin MIN v(outb)
meas dc bmax MAX v(outb)
echo "  >>> Output range: $&bmin .. $&bmax V"
echo "  >>> No ceiling exists in 0..3.3: the part is valid everywhere N1_SUM"
echo "  >>> can go. (On the LM339 this sweep found a ceiling at 1.30045 V.)"
wrdata results/tb06b_cmmap.txt v(outb)

echo ""
echo "==================================================================="
echo "TB06 (C) HYSTERESIS / CHATTER at the REAL 1.65 V reference"
echo "==================================================================="
echo "  Slow ramp 1.64->1.66 V over 40 ms (0.5 V/s) + 2 mV 100 Hz flicker"
echo "  + 200 uV RMS broadband noise. Identical stimulus to the LM339 run,"
echo "  which produced ~750 transitions across a 7.5 ms window."
tran 2u 40m
echo "  Transient written to results/tb06c_chatter.txt"
echo "  (edge count is produced by results/count_edges.py)"
wrdata results/tb06c_chatter.txt v(outc) v(nnz) v(nrefc)

quit
.endc

.end
