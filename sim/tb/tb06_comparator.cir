* TB06 - Comparator stage (U10 LM339 unit 1) + LED indicator
*
* Schematic: U10 pin 7 (1IN+) = N1_SUM
*            U10 pin 6 (1IN-) = V_REF_BUF = 1.65 V
*            U10 pin 1 (1OUT) = open collector
*            +3.3V -- R30 1k -- D1 (LED) -- 1OUT     => LED lights when OUT LOW
*            No hysteresis resistor anywhere. No logic pull-up. OUT is not read
*            back by the STM32 -- the LED is the only consumer.
*
* THREE SEPARATE QUESTIONS, tested separately so they cannot be confused:
*   (A) As-designed DC sweep: does the comparator work at all with IN- = 1.65?
*   (B) CM-range map: where in the (IN+, IN-) plane is the part actually valid?
*   (C) Hysteresis/chatter: with the reference moved into a VALID range, what
*       does a slow noisy crossing do to the output?
*   (D) LED drive current.
*
* CM RANGE FACTS (keep these distinct):
*   - TI LM339 datasheet: Vicm = 0 .. Vcc-1.5  => 0 .. 1.80 V at Vcc=3.3
*   - TI's own PSpice macromodel enforces Vcc-2.0 => 0 .. 1.30 V at Vcc=3.3
*   The model is the more conservative of the two. Where the model's INPUTRANGE
*   block trips, its Output_Stage is forced to MID-SUPPLY (1.65 V) via the SMID
*   switch. That 1.65 V is NOT a physical prediction -- it is TI's "this model
*   is outside its validity region" flag. Real silicon does something else
*   (typically phase inversion or a stuck output), which is precisely why the
*   datasheet does not guarantee behaviour there.
*
* From TB05: N1_SUM operating range is 0.20 V .. 3.10 V.

.include ../models/LM2901.lib
.options gmin=100f
.param VDD=3.3

* Red LED, tuned to Vf ~ 1.9 V at 1 mA (WL-TMRC 5mm). Exact Vf is not critical:
* it only shifts the LED current, not the comparator logic.
.model LED_RED D(IS=2e-18 N=2.0 RS=2 CJO=30p)

Vdd  vdd 0 DC {VDD}

* --- (A) as-designed: IN- pinned at the 1.65 V pseudo-ground ---
Vrefa nrefa 0 DC 1.65
Vsum  nsum  0 DC 1.65
XC1   nsum nrefa vdd 0 outa LM2901
R30   vdd  nled  1k
D1    nled outa  LED_RED

* --- (B) CM map: IN- parked at 0.80 V (safely inside every stated limit) and
* --- IN+ swept upward, to locate the exact voltage where the part stops
* --- behaving as a comparator. Pinning IN+ at 1.65 (as an earlier revision of
* --- this deck did) is useless: 1.65 is itself out of range, so nothing valid
* --- can be learned from the sweep.
Vrefb nrefb 0 DC 0.80
Vsumb nsumb 0 DC 0.5
XC2   nsumb nrefb vdd 0 outb LM2901
Rpub  vdd outb 10k

* --- (C) chatter rig: reference moved DOWN to 1.0 V (inside the model's valid
* --- range) so that the hysteresis question is tested in isolation from the
* --- common-mode question. Slow ramp + realistic interference.
Vrefc nrefc 0 DC 1.0
* Slow crossing: the LDR has 60 ms rise, so N_SUM slews on the order of V/s.
* Ramp 0.99 -> 1.01 over 40 ms == 0.5 V/s at the sum node.
Vrampc nrampc 0 DC 0 PWL(0 0.99 40m 1.01)
* Interference: mains-lit rooms flicker at 100/120 Hz and an LDR sees it
* directly. 2 mV pk at the sum node is a modest, realistic estimate
* (TB05 measured 18.6 uV of intrinsic thermal noise -- flicker dominates).
*
* PHASE MATTERS, and an earlier revision of this deck got a misleading result
* by ignoring it. At t=20 ms (where the ramp crosses the threshold) the phase
* is sin(4*pi)=0; with phase 0 the flicker's slope ADDS to the ramp's, the
* crossing stays monotonic, and exactly one clean transition occurs. That is
* the lucky case, not the representative one. PHASE=180 puts the flicker's
* steepest FALLING edge on the crossing, which is the worst case.
*
* The general condition is phase-independent and is the real point:
* chatter occurs whenever the interference slew rate exceeds the signal's.
*   interference peak slope = A*2*pi*f = 2mV * 628 = 1.26 V/s
*   signal slope at the sum  = 0.5 V/s  (LDR 60 ms rise, x0.22 summer gain)
* 1.26 > 0.5, so ANY flicker above ~0.8 mV chatters this comparator.
Vflick nflick nrampc SIN(0 2m 100 0 0 180)
* Broadband noise on top, 200 uV RMS, 1 us step -- represents supply and
* sensor noise rather than the deterministic mains component.
Vnoise nnz nflick DC 0 trnoise(200u 1u 0 0)
XC3    nnz nrefc vdd 0 outc LM2901
Rpuc   vdd outc 10k

.control
set wr_singlescale

echo "==================================================================="
echo "TB06 (A) AS DESIGNED: IN- = V_REF_BUF = 1.65 V, sweep N1_SUM"
echo "==================================================================="
dc Vsum 0 3.3 0.005
meas dc a_0v2  find v(outa) at=0.2
meas dc a_1v0  find v(outa) at=1.0
meas dc a_1v4  find v(outa) at=1.4
meas dc a_1v6  find v(outa) at=1.6
meas dc a_1v7  find v(outa) at=1.7
meas dc a_2v0  find v(outa) at=2.0
meas dc a_3v1  find v(outa) at=3.1
echo "  N1_SUM=0.20 (below ref -> expect LED ON,  OUT LOW)  -> OUT = $&a_0v2 V"
echo "  N1_SUM=1.00 (below ref -> expect LED ON,  OUT LOW)  -> OUT = $&a_1v0 V"
echo "  N1_SUM=1.40 (below ref -> expect LED ON,  OUT LOW)  -> OUT = $&a_1v4 V"
echo "  N1_SUM=1.60 (below ref -> expect LED ON,  OUT LOW)  -> OUT = $&a_1v6 V"
echo "  N1_SUM=1.70 (above ref -> expect LED OFF, OUT HIGH) -> OUT = $&a_1v7 V"
echo "  N1_SUM=2.00 (above ref -> expect LED OFF, OUT HIGH) -> OUT = $&a_2v0 V"
echo "  N1_SUM=3.10 (above ref -> expect LED OFF, OUT HIGH) -> OUT = $&a_3v1 V"
let ledi = (v(vdd)-v(nled))/1000
meas dc li_0v2 find ledi at=0.2
meas dc li_3v1 find ledi at=3.1
echo "  LED current at N1_SUM=0.20 = $&li_0v2 A"
echo "  LED current at N1_SUM=3.10 = $&li_3v1 A"
wrdata results/tb06a_asdesigned.txt v(outa) ledi

echo ""
echo "==================================================================="
echo "TB06 (B) COMMON-MODE MAP: IN- = 0.80 V (valid), sweep IN+ upward"
echo "==================================================================="
* Correct behaviour: OUT LOW while IN+ < 0.80, OUT HIGH above it, and HIGH
* should persist all the way to the rail. Where OUT leaves a valid logic level
* is the usable common-mode ceiling.
dc Vsumb 0 3.3 0.0025
meas dc b_0v5 find v(outb) at=0.5
meas dc b_0v9 find v(outb) at=0.9
meas dc b_1v2 find v(outb) at=1.2
meas dc b_1v3 find v(outb) at=1.3
meas dc b_1v4 find v(outb) at=1.4
meas dc b_1v8 find v(outb) at=1.8
meas dc b_2v5 find v(outb) at=2.5
meas dc b_3v1 find v(outb) at=3.1
echo "  IN+=0.50 (below ref -> expect LOW)  -> OUT = $&b_0v5 V"
echo "  IN+=0.90 (above ref -> expect HIGH) -> OUT = $&b_0v9 V"
echo "  IN+=1.20 (above ref -> expect HIGH) -> OUT = $&b_1v2 V"
echo "  IN+=1.30 (model CM limit Vcc-2.0)   -> OUT = $&b_1v3 V"
echo "  IN+=1.40 (past model CM limit)      -> OUT = $&b_1v4 V"
echo "  IN+=1.80 (datasheet CM limit)       -> OUT = $&b_1v8 V"
echo "  IN+=2.50 (N1_SUM reaches here)      -> OUT = $&b_2v5 V"
echo "  IN+=3.10 (N1_SUM max)               -> OUT = $&b_3v1 V"
* Locate the ceiling precisely: first point where OUT falls below a valid HIGH.
meas dc cm_ceiling when v(outb)=3.0 fall=1
echo "  >>> Usable IN+ ceiling (OUT leaves valid HIGH) = $&cm_ceiling V"
wrdata results/tb06b_cmmap.txt v(outb)

echo ""
echo "==================================================================="
echo "TB06 (C) HYSTERESIS / CHATTER, reference relocated to 1.0 V"
echo "==================================================================="
echo "  Slow ramp 0.99->1.01 V over 40 ms (0.5 V/s) + 2 mV 100 Hz flicker."
echo "  With zero hysteresis every flicker excursion re-crosses the threshold."
tran 2u 40m
* Transition counting is done in post (count_edges.py): deriv() on a
* square-ish waveform makes ngspice's polyfit fail, so the raw trace is
* exported and edges are counted there instead.
echo "  Transient written to results/tb06c_chatter.txt"
echo "  (edge count is produced by results/count_edges.py)"
wrdata results/tb06c_chatter.txt v(outc) v(nnz) v(nrefc)

quit
.endc

.end
